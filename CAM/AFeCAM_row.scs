simulator lang=spectre
format options rawfmt=psfascii
global 0

//libraries
ahdl_include "./VerilogA_Code/bsimcmg_FE.va"
include "./Ferro_FinFET.pm"
include "./Original_FinFET_L72.pm"

parameters tmp_self=27

nFETr1c1 (ml1 blg1   vss vss) nFeFET dir_init=1 time_step=5n tauo=5.4782e-8 Vo=5.8585 m=1.3434 Ps=41.2e-6    Pr=23.9e-6    Ec=1.1048e6    epison_FE=30 PHIG=4.8187
nFETr1c2 (ml1 blg2   vss vss) nFeFET dir_init=1 time_step=5n tauo=5.4782e-8 Vo=5.8585 m=1.3434 Ps=41.2e-6    Pr=23.9e-6    Ec=1.1048e6    epison_FE=30 PHIG=4.8187
nFETr1c3 (ml1 blg3   vss vss) nFeFET dir_init=1 time_step=5n tauo=5.4782e-8 Vo=5.8585 m=1.3434 Ps=41.2e-6    Pr=23.9e-6    Ec=1.1048e6    epison_FE=30 PHIG=4.8187
nFETr1c4 (ml1 blg4   vss vss) nFeFET dir_init=1 time_step=5n tauo=5.4782e-8 Vo=5.8585 m=1.3434 Ps=41.2e-6    Pr=23.9e-6    Ec=1.1048e6    epison_FE=30 PHIG=4.8187

nFETr1c5 (ml1 blg5   vss vss) nFeFET dir_init=1 time_step=5n tauo=5.4782e-8 Vo=5.8585 m=1.3434 Ps=41.2e-6    Pr=23.9e-6    Ec=1.1048e6    epison_FE=30 PHIG=4.8187
nFETr1c6 (ml1 blg6   vss vss) nFeFET dir_init=1 time_step=5n tauo=5.4782e-8 Vo=5.8585 m=1.3434 Ps=41.2e-6    Pr=23.9e-6    Ec=1.1048e6    epison_FE=30 PHIG=4.8187
nFETr1c7 (ml1 blg7   vss vss) nFeFET dir_init=1 time_step=5n tauo=5.4782e-8 Vo=5.8585 m=1.3434 Ps=41.2e-6    Pr=23.9e-6    Ec=1.1048e6    epison_FE=30 PHIG=4.8187
nFETr1c8 (ml1 blg8   vss vss) nFeFET dir_init=1 time_step=5n tauo=5.4782e-8 Vo=5.8585 m=1.3434 Ps=41.2e-6    Pr=23.9e-6    Ec=1.1048e6    epison_FE=30 PHIG=4.8187

/////////////////////////////////////////////////////////////////
//CSR Sense amplifier Ckt taken from Cross-layer FeFET Reliability Modeling for Robust Hyperdimensional Computing

pFET_P1 (mlg clk vdd0 vdd0) PFET l=45n w=130n

pFET_invsa (o1 mlg vdd0 vdd0) PFET l=45n w=130n
nFET_invsa (o1 mlg 0 0) NFET l=45n w=65n
pFET_invsa1 (vsa_out o1 vdd0 vdd0) PFET l=45n w=130n
nFET_invsa1 (vsa_out o1 0 0) NFET l=45n w=65n

nFET_N1 (mlg g1 ml ml) NFET l=45n w=65n

pFET_invd (g1 ml vdd0 vdd0) PFET l=45n w=130n
nFET_invd (g1 ml 0 0) NFET l=45n w=65n

pFET_invdo2 (s1 clk vdd0 vdd0) PFET l=45n w=130n
pFET_invdo1 (g1 ml s1 s1) PFET l=45n w=130n
nFET_invdo1 (g1 ml s2 s2) NFET l=45n w=65n
nFET_invdo2 (s2 clk 0 0) NFET l=45n w=65n
///////////////////////////////////////////////////////////

///////////////////////////////////////////////////////////

pFET_invnew (new vsa_out vdd0 vdd0) PFET l=45n w=130n
nFET_invnew (new vsa_out 0 0) NFET l=45n w=65n
/////////////////////////////////////////////////////////////////////

//Capacitors
//Cload (and vss) capacitor c=0.15fF
/////////////////////////////////////////////////////////////////////
**********voltage supplies**********
Vvss    (vss 0) vsource type=dc dc=0
Vml    (ml ml1) vsource type=dc dc=0

Vvdd0    (vdd0 0) vsource type=pwl scale=1 wave=[0 0 43.04900u 0 43.04901u 1.3]

Vclk    (clk 0) vsource type=pwl scale=1 wave=[0 0 43.05u 0 43.05001u 1 43.05501u 1 43.05502u 0 43.06002u 0 43.06003u 1 43.06503u 1 43.06504u 0]

Vin1_1  (blg1  0) vsource type=pwl scale=1 wave=[0 0 1u 0 1.01u 5 11.01u 5 11.02u 0 30u 0 30010n -4 30079n -4 30089n 0 43.05u  0 43.05001u 1 43.05501u 1  43.05502u 0 43.06002u 0 43.06003u 1 43.06503u 1 43.06504u 0]
Vin1_2  (blg2  0) vsource type=pwl scale=1 wave=[0 0 1u 0 1.01u 5 11.01u 5 11.02u 0 30u 0 30010n -4 30079n -4 30089n 0 43.05u  0 43.05001u 1 43.05501u 1  43.05502u 0 43.06002u 0 43.06003u 0 43.06503u 0 43.06504u 0]
Vin1_3  (blg3  0) vsource type=pwl scale=1 wave=[0 0 1u 0 1.01u 5 11.01u 5 11.02u 0 30u 0 30010n -4 30079n -4 30089n 0 43.05u  0 43.05001u 0 43.05501u 0  43.05502u 0 43.06002u 0 43.06003u 0 43.06503u 0 43.06504u 0]
Vin1_4  (blg4  0) vsource type=pwl scale=1 wave=[0 0 1u 0 1.01u 5 11.01u 5 11.02u 0 30u 0 30010n -4 30079n -4 30089n 0 43.05u  0 43.05001u 0 43.05501u 0  43.05502u 0 43.06002u 0 43.06003u 0 43.06503u 0 43.06504u 0]
Vin1_5  (blg5  0) vsource type=pwl scale=1 wave=[0 0 1u 0 1.01u 5 11.01u 5 11.02u 0 30u 0 30010n -4 30079n -4 30089n 0 43.05u  0 43.05001u 0 43.05501u 0  43.05502u 0 43.06002u 0 43.06003u 0 43.06503u 0 43.06504u 0]
Vin1_6  (blg6  0) vsource type=pwl scale=1 wave=[0 0 1u 0 1.01u 5 11.01u 5 11.02u 0 30u 0 30010n -4 30079n -4 30089n 0 43.05u  0 43.05001u 0 43.05501u 0  43.05502u 0 43.06002u 0 43.06003u 0 43.06503u 0 43.06504u 0]
Vin1_7  (blg7  0) vsource type=pwl scale=1 wave=[0 0 1u 0 1.01u 5 11.01u 5 11.02u 0 30u 0 30010n -4 30079n -4 30089n 0 43.05u  0 43.05001u 0 43.05501u 0  43.05502u 0 43.06002u 0 43.06003u 0 43.06503u 0 43.06504u 0]
Vin1_8  (blg8  0) vsource type=pwl scale=1 wave=[0 0 1u 0 1.01u 5 11.01u 5 11.02u 0 30u 0 30010n 4 30079n 4 30089n 0 43.05u  0 43.05001u 0 43.05501u 0  43.05502u 0 43.06002u 0 43.06003u 1 43.06503u 1 43.06504u 0]

simulatorOptions options reltol=1e-6 vabstol=1e-6 iabstol=1e-12 temp=tmp_self \
    tnom=27 scalem=1.0 scale=1.0 gmin=1e-12 rforce=1 maxnotes=5 maxwarns=5 \
    digits=0 cols=80 pivrel=1e-3 sensfile="../psf/sens.output" \
    checklimitdest=psf saveahdlvars=all

preRun tran stop=70.7u outputstart=0u minstep=1p maxstep=10u writefinal="spectre.fc" annotate=status maxiters=10 autostop=yes method=trapeuler

measureRun tran stop=70.7u outputstart=70.6u minstep=1p maxstep=10u writefinal="spectre.fc" annotate=status maxiters=10 autostop=yes method=trapeuler

modelParameter info what=models where=rawfile
element info what=inst where=rawfile
outputParameter info what=output where=rawfile
designParamVals info what=parameters where=rawfile
primitives info what=primitives where=rawfile
subckts info what=subckts  where=rawfile
saveOptions options save=all

***********************************************
********** CMOS PTM 45nm models ***************
***********************************************
simulator lang=spectre

parameters vth0n=0.466 vth0p=-0.4118
*parameters vth0n=1 vth0p=-1
parameters vvthn=0 vvthp=0
parameters vl=0 vw=0
parameters r=1.5

* Beta Version released on 2/22/06
* PTM 45nm NMOS
inline subckt NFET (D G S B)
parameters w=defw l=defl as=(defw*r*defl) ad=(defw*r*defl)
+ ps=2*(defw+r*defl) pd=2*(defw+r*defl)
NFET (D G S B) NFET w=(w+vw) l=(l+vl)
+ as=(w+vw)*r*(l+vl) ad=(w+vw)*r*(l+vl)
+ ps=2*(w+vw+r*(l+vl)) pd=2*(w+vw+r*(l+vl))
model NFET bsim4
+version = 4.0 binunit = 1 paramchk= 1 mobmod = 0
+capmod = 2 igcmod = 1 igbmod = 1 geomod = 1
+diomod = 1 rdsmod = 0 rbodymod= 1 rgatemod= 1
+permod = 1 acnqsmod= 0 trnqsmod= 0
+tnom = 27 toxe = 1.75e-9 toxp = 1.1e-9 toxm = 1.75e-9 type = n
+dtox = 0.65e-9 epsrox = 3.9 wint = 5e-009 lint = 3.75e-009
+ll = 0 wl = 0 lln = 1 wln = 1
+lw = 0 ww = 0 lwn = 1 wwn = 1
+lwl = 0 wwl = 0 xpart = 0 toxref = 1.75e-9
+xl = -20e-9
+vth0 = (vth0n+vvthn) k1 = 0.4 k2 = 0.0 k3 = 0
+k3b = 0 w0 = 2.5e-006 dvt0 = 1 dvt1 = 2
+dvt2 = 0 dvt0w = 0 dvt1w = 0 dvt2w = 0
+dsub = 0.1 minv = 0.05 voffl = 0 dvtp0 = 1.0e-010
+dvtp1 = 0.1 lpe0 = 0 lpeb = 0 xj = 1.4e-008
+ngate = 2e+020 ndep = 3.24e+018 nsd = 2e+020 phin = 0
+cdsc = 0.000 cdscb = 0 cdscd = 0 cit = 0
+voff = -0.13 nfactor = 2.1 eta0 = 0.0049 etab = 0
+vfb = -0.55 u0 = 0.04398 ua = 6e-010 ub = 1.2e-018
+uc = 0 vsat = 147390 a0 = 1.0 ags = 0
+a1 = 0 a2 = 1.0 b0 = 0 b1 = 0
+keta = 0.04 dwg = 0 dwb = 0 pclm = 0.02
+pdiblc1 = 0.001 pdiblc2 = 0.001 pdiblcb = -0.005 drout = 0.5
+pvag = 1e-020 delta = 0.01 pscbe1 = 8.14e+008 pscbe2 = 1e-007
+fprout = 0.2 pdits = 0.08 pditsd = 0.23 pditsl = 2.3e+006
+rsh = 5 rdsw = 155 rsw = 80 rdw = 80
+rdswmin = 0 rdwmin = 0 rswmin = 0 prwg = 0
+prwb = 0 wr = 1 alpha0 = 0.074 alpha1 = 0.005
+beta0 = 30 agidl = 0.0002 bgidl = 2.1e+009 cgidl = 0.0002
+egidl = 0.8
+aigbacc = 0.012 bigbacc = 0.0028 cigbacc = 0.002
+nigbacc = 1 aigbinv = 0.014 bigbinv = 0.004 cigbinv = 0.004
+eigbinv = 1.1 nigbinv = 3 aigc = 0.012 bigc = 0.0028
+cigc = 0.002 aigsd = 0.012 bigsd = 0.0028 cigsd = 0.002
+nigc = 1 poxedge = 1 pigcd = 1 ntox = 1
+xrcrg1 = 12 xrcrg2 = 5
+cgso = 1.1e-010 cgdo = 1.1e-010 cgbo = 2.56e-011 cgdl = 2.653e-10
+cgsl = 2.653e-10 ckappas = 0.03 ckappad = 0.03 acde = 1
+moin = 15 noff = 0.9 voffcv = 0.02
+kt1 = -0.11 kt1l = 0 kt2 = 0.022 ute = -1.5
+ua1 = 4.31e-009 ub1 = 7.61e-018 uc1 = -5.6e-011 prt = 0
+at = 33000
+fnoimod = 1 tnoimod = 0
+jss = 0.0001 jsws = 1e-011 jswgs = 1e-010 njs = 1
+ijthsfwd= 0.01 ijthsrev= 0.001 bvs = 10 xjbvs = 1
+jsd = 0.0001 jswd = 1e-011 jswgd = 1e-010 njd = 1
+ijthdfwd= 0.01 ijthdrev= 0.001 bvd = 10 xjbvd = 1
+pbs = 1 cjs = 0.0005 mjs = 0.5 pbsws = 1
+cjsws = 5e-010 mjsws = 0.33 pbswgs = 1 cjswgs = 3e-010
+mjswgs = 0.33 pbd = 1 cjd = 0.0005 mjd = 0.5
+pbswd = 1 cjswd = 5e-010 mjswd = 0.33 pbswgd = 1
+cjswgd = 5e-010 mjswgd = 0.33 tpb = 0.005 tcj = 0.001
+tpbsw = 0.005 tcjsw = 0.001 tpbswg = 0.005 tcjswg = 0.001
+xtis = 3 xtid = 3
+dmcg = 0e-006 dmci = 0e-006 dmdg = 0e-006 dmcgt = 0e-007
+dwj = 0.0e-008 xgw = 0e-007 xgl = 0e-008
+rshg = 0.4 gbmin = 1e-010 rbpb = 5 rbpd = 15
+rbps = 15 rbdb = 15 rbsb = 15 ngcon = 1
ends NFET

* PTM 45nm PMOS
inline subckt PFET (D G S B)
parameters w=defw l=defl as=(defw*r*defl) ad=(defw*r*defl)
+ ps=2*(defw+r*defl) pd=2*(defw+r*defl)
PFET (D G S B) PFET w=(w+vw) l=(l+vl)
+ as=(w+vw)*r*(l+vl) ad=(w+vw)*r*(l+vl)
+ ps=2*(w+vw+r*(l+vl)) pd=2*(w+vw+r*(l+vl))
model PFET bsim4
+version = 4.0 binunit = 1 paramchk= 1 mobmod = 0
+capmod = 2 igcmod = 1 igbmod = 1 geomod = 1
+diomod = 1 rdsmod = 0 rbodymod= 1 rgatemod= 1
+permod = 1 acnqsmod= 0 trnqsmod= 0
+tnom = 27 toxe = 1.85e-009 toxp = 1.1e-009 toxm = 1.85e-009 type = p
+dtox = 0.75e-9 epsrox = 3.9 wint = 5e-009 lint = 3.75e-009
+ll = 0 wl = 0 lln = 1 wln = 1
+lw = 0 ww = 0 lwn = 1 wwn = 1
+lwl = 0 wwl = 0 xpart = 0 toxref = 1.85e-009
+xl = -20e-9
+vth0 = (vvthp+vth0p) k1 = 0.4 k2 = -0.01 k3 = 0
+k3b = 0 w0 = 2.5e-006 dvt0 = 1 dvt1 = 2
+dvt2 = -0.032 dvt0w = 0 dvt1w = 0 dvt2w = 0
+dsub = 0.1 minv = 0.05 voffl = 0 dvtp0 = 1e-011
+dvtp1 = 0.05 lpe0 = 0 lpeb = 0 xj = 1.4e-008
+ngate = 2e+020 ndep = 2.44e+018 nsd = 2e+020 phin = 0
+cdsc = 0.000 cdscb = 0 cdscd = 0 cit = 0
+voff = -0.126 nfactor = 2.1 eta0 = 0.0049 etab = 0
+vfb = 0.55 u0 = 0.00440 ua = 2.0e-009 ub = 0.5e-018
+uc = 0 vsat = 70000 a0 = 1.0 ags = 1e-020
+a1 = 0 a2 = 1 b0 = 0 b1 = 0
+keta = -0.047 dwg = 0 dwb = 0 pclm = 0.12
+pdiblc1 = 0.001 pdiblc2 = 0.001 pdiblcb = 3.4e-008 drout = 0.56
+pvag = 1e-020 delta = 0.01 pscbe1 = 8.14e+008 pscbe2 = 9.58e-007
+fprout = 0.2 pdits = 0.08 pditsd = 0.23 pditsl = 2.3e+006
+rsh = 5 rdsw = 155 rsw = 75 rdw = 75
+rdswmin = 0 rdwmin = 0 rswmin = 0 prwg = 0
+prwb = 0 wr = 1 alpha0 = 0.074 alpha1 = 0.005
+beta0 = 30 agidl = 0.0002 bgidl = 2.1e+009 cgidl = 0.0002
+egidl = 0.8
+aigbacc = 0.012 bigbacc = 0.0028 cigbacc = 0.002
+nigbacc = 1 aigbinv = 0.014 bigbinv = 0.004 cigbinv = 0.004
+eigbinv = 1.1 nigbinv = 3 aigc = 0.69 bigc = 0.0012
+cigc = 0.0008 aigsd = 0.0087 bigsd = 0.0012 cigsd = 0.0008
+nigc = 1 poxedge = 1 pigcd = 1 ntox = 1
+xrcrg1 = 12 xrcrg2 = 5
+cgso = 1.1e-010 cgdo = 1.1e-010 cgbo = 2.56e-011 cgdl = 2.653e-10
+cgsl = 2.653e-10 ckappas = 0.03 ckappad = 0.03 acde = 1
+moin = 15 noff = 0.9 voffcv = 0.02
+kt1 = -0.11 kt1l = 0 kt2 = 0.022 ute = -1.5
+ua1 = 4.31e-009 ub1 = 7.61e-018 uc1 = -5.6e-011 prt = 0
+at = 33000
+fnoimod = 1 tnoimod = 0
+jss = 0.0001 jsws = 1e-011 jswgs = 1e-010 njs = 1
+ijthsfwd= 0.01 ijthsrev= 0.001 bvs = 10 xjbvs = 1
+jsd = 0.0001 jswd = 1e-011 jswgd = 1e-010 njd = 1
+ijthdfwd= 0.01 ijthdrev= 0.001 bvd = 10 xjbvd = 1
+pbs = 1 cjs = 0.0005 mjs = 0.5 pbsws = 1
+cjsws = 5e-010 mjsws = 0.33 pbswgs = 1 cjswgs = 3e-010
+mjswgs = 0.33 pbd = 1 cjd = 0.0005 mjd = 0.5
+pbswd = 1 cjswd = 5e-010 mjswd = 0.33 pbswgd = 1
+cjswgd = 5e-010 mjswgd = 0.33 tpb = 0.005 tcj = 0.001
+tpbsw = 0.005 tcjsw = 0.001 tpbswg = 0.005 tcjswg = 0.001
+xtis = 3 xtid = 3
+dmcg = 0e-006 dmci = 0e-006 dmdg = 0e-006 dmcgt = 0e-007
+dwj = 0.0e-008 xgw = 0e-007 xgl = 0e-008
+rshg = 0.4 gbmin = 1e-010 rbpb = 5 rbpd = 15
+rbps = 15 rbdb = 15 rbsb = 15 ngcon = 1
ends PFET
